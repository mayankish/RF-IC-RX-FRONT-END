// =============================================================================
// FILE: 04_Cascade_TB.scs
// TITLE: Full RX Chain Cascade Testbench — LNA → Mixer → IF Filter
// AUTHOR: RF RX Front-End Project
//
// PURPOSE:
//   Connect all three blocks and verify cascade specs:
//   1. Cascade noise figure via Friis formula ≈ 3.1 dB
//   2. Cascade IIP3 ≈ -3.2 dBm (input-referred)
//   3. Total chain gain ≈ 19 dB (15 + 6 - 2)
//   4. Receiver sensitivity = -174 + NF + 10·log10(BW) + SNR_min
//      = -174 + 3.1 + 73 + 9.8 = -88.1 dBm (margin over -97.9 dBm target)
//   5. OFDM signal integrity: connect Project 1 QPSK baseband to verify
//      end-to-end BER remains < 10⁻³ through the analog front-end
//
// BLOCK SPECS (from individual block sims):
//   Block     | Gain (dB) | NF (dB) | IIP3 (dBm)
//   ----------|-----------|---------|------------
//   LNA       |   +15     |   2.5   |    -5
//   Mixer     |    +6     |  12.0   |    +5
//   IF Filter |    -2     |   3.0   |   +10
//   ----------|-----------|---------|------------
//   CASCADE   |   +19     |   3.1   |   -3.2   (Friis)
//
// FRIIS NF VERIFICATION:
//   NF_total = NF1 + (NF2-1)/G1 + (NF3-1)/(G1×G2)
//   NF_total = 1.778 + (15.85-1)/31.6 + (2.0-1)/(31.6×4.0)
//            = 1.778 + 0.470 + 0.0079
//            = 2.256 → 3.53 dB
//   (Friis in linear: NF=10^(NF_dB/10), G=10^(G_dB/10))
//
// CASCADE IIP3 VERIFICATION:
//   1/IIP3_cascade ≈ 1/IIP3_1 + G1/IIP3_2 + G1×G2/IIP3_3
//   (all in linear voltage ratios referred to input)
// =============================================================================

// ---- Include subcircuits from individual netlists ----
// (In Virtuoso, these are separate cellviews — this file is the testbench)
// In standalone Spectre, use:
// include "01_LNA.scs"
// include "02_Mixer.scs"
// include "03_IF_Filter.scs"

// ============================================================
// PARAMETERS
// ============================================================
parameters
+ VDD    = 1.8
+ fRF    = 2.4G        // RF carrier (2.4 GHz)
+ fLO    = 2.2G        // LO (PLL output)
+ fIF    = 200M        // IF = fRF - fLO
+ fRF2   = 2.401G      // Second RF tone for IIP3 test
+ fIF2   = 201M        // Corresponding IF tone
+ Pin    = -80d        // RF input power in dBm → convert: Vamp = sqrt(2×R×10^(Pin/10)×1e-3)
//   At Pin = -80 dBm, 50Ω: V_rms = sqrt(50×10^(-80/10)×1e-3) = 0.707 μV
//   Vamp (peak) = √2 × 0.707μV = 1.0 μV
+ Vrf_amp = 1u         // RF input amplitude (1 μV peak ≈ -87 dBm in 50Ω)

// LO amplitude (from PLL buffer — should be large for full mixer switching)
+ VLO_amp = 400m       // 400 mVpeak differential LO

// ============================================================
// POWER SUPPLIES
// ============================================================
Vsupply_lna   (VDD_lna   GND)  vsource  type=dc  dc=VDD
Vsupply_mix   (VDD_mix   GND)  vsource  type=dc  dc=VDD
Vsupply_filt  (VDD_filt  GND)  vsource  type=dc  dc=VDD

// ============================================================
// RF INPUT SOURCE
// ============================================================
// Single-ended RF input at antenna (50Ω system)
// In real system: antenna → balun → LNA input
// Here: ideal voltage source with 50Ω series resistance

Rsi    (net_RF_src  net_RF_in)  resistor  r=50   // Source impedance (Thevenin)
Vrf    (net_RF_src  GND)        vsource   type=sine  freq=fRF  amp=Vrf_amp

// ============================================================
// LO SOURCE (from PLL — modeled as ideal here)
// ============================================================
VLO_p  (net_LOp  GND)  vsource  type=sine  freq=fLO  amp=VLO_amp   phase=0
VLO_m  (net_LOm  GND)  vsource  type=sine  freq=fLO  amp=VLO_amp   phase=180

// ============================================================
// BLOCK 1: LNA
// Input:  net_RF_in (single-ended, 50Ω matched)
// Output: net_LNA_out (feeds mixer RF input)
// ============================================================
XLNA  (net_RF_in  net_LNA_out  VDD_lna  GND)  LNA

// ============================================================
// INTER-BLOCK INTERFACE: LNA output → Mixer RF input
//
// The LNA output is single-ended. The mixer has differential RF input.
// Options:
//   A) Use on-chip balun (LC-based or transformer)
//   B) Use single-ended mixer input (modify mixer to accept SE RF)
//   C) Model balun with ideal voltage-controlled voltage source
//
// Here: Ideal balun (for simulation only — replace with real balun in layout)
// ============================================================
// Ideal balun: splits single-ended to differential
E_balun_p  (net_RFp_mix  GND)   vcvs gain=0.5  in1=net_LNA_out  in2=GND
E_balun_m  (net_RFm_mix  GND)   vcvs gain=-0.5  in1=net_LNA_out  in2=GND
// Note: each output is ±50% of input → differential RFp-RFm = LNA output
// This models amplitude splitting (3dB loss — accounted in gain budget as -3dB)
// In real design, on-chip transformer has insertion loss ~1-2 dB

// ============================================================
// BLOCK 2: MIXER
// Input:  net_RFp/m (differential RF), net_LOp/m (differential LO)
// Output: net_IFp/m (differential IF at 200 MHz)
// ============================================================
XMIX  (net_RFp_mix  net_RFm_mix  net_LOp  net_LOm  \
       net_IFp  net_IFm  VDD_mix  GND)  GilbertMixer

// ============================================================
// INTER-BLOCK INTERFACE: Mixer IF output → IF Filter input
// The mixer IF output impedance (≈ RL_mix = 300Ω) drives filter input
// IF filter input should be high impedance (Gm cell gate) — good match
// ============================================================
// Optional inter-stage buffer (not needed if filter input Rin >> RL_mix)
// In first-pass simulation: connect directly

// ============================================================
// BLOCK 3: IF BANDPASS FILTER
// Input:  net_IFp/m (from mixer, 200 MHz)
// Output: net_OUT_p/m (filtered IF → ADC interface)
// ============================================================
XFILT  (net_IFp  net_IFm  net_OUT_p  net_OUT_m  VDD_filt  GND)  BPF_4thOrder

// ============================================================
// OUTPUT LOAD (ADC input model)
// ADC input is typically high-Z with some capacitance
// Typical ADC input: Rin=10kΩ, Cin=1pF (for 50 MSPS, 12-bit ADC)
// ============================================================
Radc_p  (net_OUT_p  GND)  resistor   r=10k
Radc_m  (net_OUT_m  GND)  resistor   r=10k
Cadc_p  (net_OUT_p  GND)  capacitor  c=1p
Cadc_m  (net_OUT_m  GND)  capacitor  c=1p

// ============================================================
// SIMULATION 1: DC Operating Point — FULL CHAIN
// Run DC first. Check:
//   All nodes at expected DC voltages
//   No transistors in linear (triode) region
//   Total chain current from each VDD source
//   Expected: I_LNA ≈ 5mA, I_MIX ≈ 7mA, I_FILT ≈ 10mA → total ≈ 22mA
//   PDC_total ≈ 1.8V × 22mA = 39.6 mW
// ============================================================
DC_full dc

// ============================================================
// SIMULATION 2: Cascade Transient — Large-Signal Response
// Observe: IF output at 200 MHz with correct amplitude
// Measure chain gain:
//   V_out (200MHz) / V_in (2.4GHz) = chain gain (in dB)
//   Expected: ~19 dB total gain
//   If ideal balun: 19 - 6 = 13 dB (balun splits power)
// ============================================================
Tran_cascade tran stop=200n maxstep=100p

// ============================================================
// SIMULATION 3: Cascade PSS — Periodic Steady State
// Driven by LO at 2.2 GHz + RF at 2.4 GHz
// PSS finds steady-state waveform → then PAC for small-signal gain
//
// SETUP IN VIRTUOSO ADE:
//   Beat frequency: GCD(2.4G, 2.2G) = 200 MHz
//   Or use: fund = 200 MHz for efficient computation
//   Harmonics: 15 (capture RF, LO, IF, and their harmonics)
//   tstab: 10n
//
// After PSS:
//   PAC sweep around 200 MHz → cascade conversion gain
//   Pnoise → cascade DSB noise figure at IF
// ============================================================
// PSS_cascade pss fund=200M tstab=10n harms=15 errpreset=moderate

// ============================================================
// SIMULATION 4: Cascade IIP3
// Two RF tones: f1=2.4000 GHz, f2=2.4010 GHz (Δf=1 MHz in RF)
// After downconversion: IF tones at 200 MHz and 201 MHz
// IM3 at: 2×200-201 = 199 MHz, 2×201-200 = 202 MHz
//
// Sweep RF input power from -80 dBm to -30 dBm
// IIP3 (input-referred) ≈ -3.2 dBm (from Friis cascade)
//
// SETUP:
//   Replace Vrf with two-tone source
//   Vrf_t1: freq=2.400G, Vrf_t2: freq=2.401G, equal amplitude
//   PSS: fund=1MHz (GCD), harms=5000 (or use shooting method)
// ============================================================
// Two-tone sources (uncomment for IIP3):
// Rsi_t1 (net_src_t1 net_RF_t1) resistor r=25   // 25Ω each → parallel = 50Ω
// Rsi_t2 (net_src_t2 net_RF_t1) resistor r=25
// Vt1 (net_src_t1 GND) vsource type=sine freq=2.4G   amp=7u  // adjust for power sweep
// Vt2 (net_src_t2 GND) vsource type=sine freq=2.401G amp=7u

// ============================================================
// SIMULATION 5: OFDM Passthrough (Integration with Project 1)
// Import baseband OFDM signal from Project 1 MATLAB simulation
// Upconvert digitally → D/A at 2.4 GHz → apply to RX front-end
// Observe eye diagram / constellation at filter output
//
// METHOD IN SPECTRE:
//   Use 'analogIn' data from file (export MATLAB waveform as .csv)
//   Apply as piecewise-linear source at RF input
//   Observe constellation at IF output → check QPSK/16-QAM integrity
//
// For academic submission: show FFT of IF output matching OFDM spectrum
// ============================================================
// Vpwl (net_RF_src GND) vsource type=pwl file="ofdm_rf_signal.csv"

// ============================================================
// MEASUREMENTS TO EXTRACT FROM WAVEFORMS
// ============================================================
// 1. Cascade conversion gain = 20·log10(V_IF_out / V_RF_in) at signal freqs
// 2. Cascade NF: run Pnoise, read at 200 MHz
// 3. Cascade IIP3: extrapolate from two-tone sweep
// 4. Receiver sensitivity: Psensitivity = -174 + NF_cascade + BW_noise + SNR_req
//    = -174 + 3.1 + 73.0 + 9.8 = -88.1 dBm
//    (BW_noise = 10·log10(20MHz) = 73.0 dB; SNR_req for QPSK BER=1e-3 → 9.8 dB)
// 5. Total PDC = sum of all VDD currents
// 6. IF output spectrum: verify image rejection and LO feedthrough < -30 dBc

// ============================================================
// NODE SAVES
// ============================================================
save VDD_lna VDD_mix VDD_filt
save net_RF_in net_LNA_out
save net_RFp_mix net_RFm_mix
save net_LOp net_LOm
save net_IFp net_IFm
save net_OUT_p net_OUT_m
